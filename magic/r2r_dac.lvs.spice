* NGSPICE file created from r2r_dac.ext - technology: gf180mcuD

.subckt bufinv_2 A Y VSS VCC
X0 Y A VCC VCC pfet_03v3 ad=2.08p pd=9.04u as=2p ps=9u w=4u l=0.28u
**devattr s=160000,2000 d=83200,1808
X1 Y A VSS VSS nfet_03v3 ad=1.04p pd=5.04u as=1p ps=5u w=2u l=0.28u
**devattr s=74000,1200 d=41600,1008
.ends

.subckt ppolyf_u_1k_NL4DCC a_2000_600# a_880_n722# a_n240_n722# a_n3600_600# a_n4372_n934#
+ a_n1920_600# a_320_600# a_3120_600# a_n240_600# a_n520_n722# a_1440_600# a_1160_n722#
+ a_n1080_n722# a_n3040_600# a_2000_n722# a_n800_n722# a_n1360_600# a_1440_n722# a_n1360_n722#
+ a_2560_600# a_2280_n722# a_880_600# a_n2480_600# a_n4160_600# a_1720_n722# a_n1640_n722#
+ a_n2200_n722# a_3680_600# a_3120_n722# a_2560_n722# a_600_600# a_n2200_600# a_n3040_n722#
+ a_n2480_n722# a_3400_600# a_n520_600# a_n1920_n722# a_1720_600# a_3400_n722# a_2840_n722#
+ a_n3320_n722# a_n3320_600# a_n1640_600# a_n2760_n722# a_3680_n722# a_n4160_n722#
+ a_2840_600# a_40_n722# a_n3600_n722# a_3960_n722# a_1160_600# a_40_600# a_n2760_600#
+ a_320_n722# a_n3880_n722# a_3960_600# a_n1080_600# a_2280_600# a_n800_600# a_600_n722#
+ a_n3880_600#
X0 a_n1640_600# a_n1640_n722# a_n4372_n934# ppolyf_u_1k r_width=1u r_length=6u
X1 a_n2760_600# a_n2760_n722# a_n4372_n934# ppolyf_u_1k r_width=1u r_length=6u
X2 a_n3880_600# a_n3880_n722# a_n4372_n934# ppolyf_u_1k r_width=1u r_length=6u
X3 a_n1360_600# a_n1360_n722# a_n4372_n934# ppolyf_u_1k r_width=1u r_length=6u
X4 a_n3320_600# a_n3320_n722# a_n4372_n934# ppolyf_u_1k r_width=1u r_length=6u
X5 a_n2480_600# a_n2480_n722# a_n4372_n934# ppolyf_u_1k r_width=1u r_length=6u
X6 a_n520_600# a_n520_n722# a_n4372_n934# ppolyf_u_1k r_width=1u r_length=6u
X7 a_n3600_600# a_n3600_n722# a_n4372_n934# ppolyf_u_1k r_width=1u r_length=6u
X8 a_n1080_600# a_n1080_n722# a_n4372_n934# ppolyf_u_1k r_width=1u r_length=6u
X9 a_n3040_600# a_n3040_n722# a_n4372_n934# ppolyf_u_1k r_width=1u r_length=6u
X10 a_n2200_600# a_n2200_n722# a_n4372_n934# ppolyf_u_1k r_width=1u r_length=6u
X11 a_n4160_600# a_n4160_n722# a_n4372_n934# ppolyf_u_1k r_width=1u r_length=6u
X12 a_n800_600# a_n800_n722# a_n4372_n934# ppolyf_u_1k r_width=1u r_length=6u
X13 a_n240_600# a_n240_n722# a_n4372_n934# ppolyf_u_1k r_width=1u r_length=6u
X14 a_1720_600# a_1720_n722# a_n4372_n934# ppolyf_u_1k r_width=1u r_length=6u
X15 a_2840_600# a_2840_n722# a_n4372_n934# ppolyf_u_1k r_width=1u r_length=6u
X16 a_1440_600# a_1440_n722# a_n4372_n934# ppolyf_u_1k r_width=1u r_length=6u
X17 a_3400_600# a_3400_n722# a_n4372_n934# ppolyf_u_1k r_width=1u r_length=6u
X18 a_3960_600# a_3960_n722# a_n4372_n934# ppolyf_u_1k r_width=1u r_length=6u
X19 a_2000_600# a_2000_n722# a_n4372_n934# ppolyf_u_1k r_width=1u r_length=6u
X20 a_2560_600# a_2560_n722# a_n4372_n934# ppolyf_u_1k r_width=1u r_length=6u
X21 a_40_600# a_40_n722# a_n4372_n934# ppolyf_u_1k r_width=1u r_length=6u
X22 a_1160_600# a_1160_n722# a_n4372_n934# ppolyf_u_1k r_width=1u r_length=6u
X23 a_3680_600# a_3680_n722# a_n4372_n934# ppolyf_u_1k r_width=1u r_length=6u
X24 a_600_600# a_600_n722# a_n4372_n934# ppolyf_u_1k r_width=1u r_length=6u
X25 a_3120_600# a_3120_n722# a_n4372_n934# ppolyf_u_1k r_width=1u r_length=6u
X26 a_2280_600# a_2280_n722# a_n4372_n934# ppolyf_u_1k r_width=1u r_length=6u
X27 a_320_600# a_320_n722# a_n4372_n934# ppolyf_u_1k r_width=1u r_length=6u
X28 a_880_600# a_880_n722# a_n4372_n934# ppolyf_u_1k r_width=1u r_length=6u
X29 a_n1920_600# a_n1920_n722# a_n4372_n934# ppolyf_u_1k r_width=1u r_length=6u
.ends

.subckt r2r_dac VGND dn[0] dn[1] dn[2] dn[3] dn[4] dn[5] dn[6] dn[7] dn[8] VPWR aout
XXdd0 dn[0] Xdd0/Y VGND VPWR bufinv_2
XXdd1 dn[1] Xdd1/Y VGND VPWR bufinv_2
XXdd2 dn[2] Xdd2/Y VGND VPWR bufinv_2
XXdd3 dn[3] Xdd3/Y VGND VPWR bufinv_2
XXdd4 dn[4] Xdd4/Y VGND VPWR bufinv_2
XXdd5 dn[5] Xdd5/Y VGND VPWR bufinv_2
XXdd7 dn[7] Xdd7/Y VGND VPWR bufinv_2
XXdd6 dn[6] Xdd6/Y VGND VPWR bufinv_2
XXdd8 dn[8] Xdd8/Y VGND VPWR bufinv_2
Xppolyf_u_1k_NL4DCC_0 Xdd6/Y m1_4930_170# m1_3250_170# m1_730_1540# VGND m1_2410_1540#
+ Xdd4/Y aout m1_4090_1540# Xdd3/Y m1_5770_1540# Xdd5/Y m1_3250_170# Xdd0/Y m1_6050_170#
+ m1_3250_170# Xdd2/Y m1_4930_170# m1_2690_170# m1_6890_1540# m1_6610_170# m1_5210_1540#
+ m1_1850_1540# VGND m1_6050_170# m1_2690_170# Xdd1/Y Xdd8/Y m1_6610_170# m1_6610_170#
+ m1_4090_1540# m1_1850_1540# m1_1010_170# m1_1570_170# aout m1_3530_1540# m1_1570_170#
+ m1_5770_1540# m1_7730_170# Xdd7/Y m1_1010_170# m1_730_1540# m1_2410_1540# m1_1570_170#
+ m1_7730_170# VGND m1_6890_1540# m1_4370_170# m1_450_170# VGND m1_5210_1540# m1_4090_1540#
+ m1_730_1540# m1_4370_170# m1_450_170# VGND m1_2410_1540# m1_5770_1540# m1_3530_1540#
+ m1_4930_170# VGND ppolyf_u_1k_NL4DCC
.ends
