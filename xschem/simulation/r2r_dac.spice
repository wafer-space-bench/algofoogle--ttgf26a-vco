** sch_path: /home/anton/projects/ttgf26a-vco/xschem/r2r_dac.sch
.subckt r2r_dac dn[8] dn[7] dn[6] dn[5] dn[4] dn[3] dn[2] dn[1] dn[0] VPWR VGND aout
*.PININFO VGND:B aout:O dn[8:0]:I VPWR:B
XR0a wi0 dd[0] VGND ppolyf_u_1k r_width=1u r_length=6u
XR0b wJ0 wi0 VGND ppolyf_u_1k r_width=1u r_length=6u
XR0c wJ0 wg0 VGND ppolyf_u_1k r_width=1u r_length=6u
XR0d wg0 VGND VGND ppolyf_u_1k r_width=1u r_length=6u
XR1a wi1 dd[1] VGND ppolyf_u_1k r_width=1u r_length=6u
XR1b wJ1 wi1 VGND ppolyf_u_1k r_width=1u r_length=6u
XR1c wJ1 wJ0 VGND ppolyf_u_1k r_width=1u r_length=6u
XR2a wi2 dd[2] VGND ppolyf_u_1k r_width=1u r_length=6u
XR2b wJ2 wi2 VGND ppolyf_u_1k r_width=1u r_length=6u
XR2c wJ2 wJ1 VGND ppolyf_u_1k r_width=1u r_length=6u
XR3a wi3 dd[3] VGND ppolyf_u_1k r_width=1u r_length=6u
XR3b wJ3 wi3 VGND ppolyf_u_1k r_width=1u r_length=6u
XR3c wJ3 wJ2 VGND ppolyf_u_1k r_width=1u r_length=6u
XR4a wi4 dd[4] VGND ppolyf_u_1k r_width=1u r_length=6u
XR4b wJ4 wi4 VGND ppolyf_u_1k r_width=1u r_length=6u
XR4c wJ4 wJ3 VGND ppolyf_u_1k r_width=1u r_length=6u
XR5a wi5 dd[5] VGND ppolyf_u_1k r_width=1u r_length=6u
XR5b wJ5 wi5 VGND ppolyf_u_1k r_width=1u r_length=6u
XR5c wJ5 wJ4 VGND ppolyf_u_1k r_width=1u r_length=6u
XR6a wi6 dd[6] VGND ppolyf_u_1k r_width=1u r_length=6u
XR6b wJ6 wi6 VGND ppolyf_u_1k r_width=1u r_length=6u
XR6c wJ6 wJ5 VGND ppolyf_u_1k r_width=1u r_length=6u
XR7a wi7 dd[7] VGND ppolyf_u_1k r_width=1u r_length=6u
XR7b wJ7 wi7 VGND ppolyf_u_1k r_width=1u r_length=6u
XR7c wJ7 wJ6 VGND ppolyf_u_1k r_width=1u r_length=6u
XR8a wi8 dd[8] VGND ppolyf_u_1k r_width=1u r_length=6u
XR8b aout wi8 VGND ppolyf_u_1k r_width=1u r_length=6u
XR8c aout wJ7 VGND ppolyf_u_1k r_width=1u r_length=6u
Xdd0 VPWR VGND dd[0] dn[0] bufinv_2
Xdd1 VPWR VGND dd[1] dn[1] bufinv_2
Xdd2 VPWR VGND dd[2] dn[2] bufinv_2
Xdd3 VPWR VGND dd[3] dn[3] bufinv_2
Xdd4 VPWR VGND dd[4] dn[4] bufinv_2
Xdd5 VPWR VGND dd[5] dn[5] bufinv_2
Xdd6 VPWR VGND dd[6] dn[6] bufinv_2
Xdd7 VPWR VGND dd[7] dn[7] bufinv_2
Xdd8 VPWR VGND dd[8] dn[8] bufinv_2
XRdummy1 VGND VGND VGND ppolyf_u_1k r_width=1u r_length=6u
XRdummy2 VGND VGND VGND ppolyf_u_1k r_width=1u r_length=6u
.ends

* expanding   symbol:  bufinv_2.sym # of pins=4
** sym_path: /home/anton/projects/ttgf26a-vco/xschem/bufinv_2.sym
** sch_path: /home/anton/projects/ttgf26a-vco/xschem/bufinv_2.sch
.subckt bufinv_2 VCC VSS Y A
*.PININFO VCC:B VSS:B A:I Y:O
XMNi Y A VSS VSS nfet_03v3 L=0.28u W=2u nf=1 ad='int((nf+1)/2) * W/nf * 0.18u' as='int((nf+2)/2) * W/nf * 0.18u' pd='2*int((nf+1)/2) * (W/nf + 0.18u)'
+ ps='2*int((nf+2)/2) * (W/nf + 0.18u)' nrd='0.18u / W' nrs='0.18u / W' sa=0 sb=0 sd=0
XMPi Y A VCC VCC pfet_03v3 L=0.28u W=4u nf=1 ad='int((nf+1)/2) * W/nf * 0.18u' as='int((nf+2)/2) * W/nf * 0.18u' pd='2*int((nf+1)/2) * (W/nf + 0.18u)'
+ ps='2*int((nf+2)/2) * (W/nf + 0.18u)' nrd='0.18u / W' nrs='0.18u / W' sa=0 sb=0 sd=0
.ends
